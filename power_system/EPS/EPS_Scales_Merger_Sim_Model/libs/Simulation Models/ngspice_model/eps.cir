.INCLUDE model/TPS1HA08B-Q1_TRANS.lib

*TITLE
.TITLE SCALES EPS REF F Simulation Model

*ELEMENT DESCRIPTIONS
VVBATT VBB 0 28
VWDENSRC WD_EN_OBC_N 0 3.3

.subckt TPS1HA08B-Q1_TRANS DIA_EN EN GND LATCH NC_0 NC_1 SEL1 SEL2 SNS ST TJ VBB VOUT_0 VOUT_1 VOUT_2 VOUT_3 VOUT_4 VOUT_5
xTPS1 DIA_EN EN 0 LATCH NC_0 NC_1 SEL1 SEL2 SNS ST TJ VBB VOUT VOUT VOUT VOUT VOUT VOUT TPS1HA08B-Q1_TRANS
.ends
C1 VBB 0 220nF
R1 WD_EN_OBC_N EN 1k
R2 VBB EN 56.2k
R3 EN 0 10k
R4 SNS 0 1k
R5 LATCH 0 15k
R6 ST 0 1k
C2 VOUT 0 22nF
R7 DIA_EN 0 15k
R8 SEL2 0 15k
R9 SEL1 0 15k

R10 VIN EN/UV 47k
R11 EN/UV 0 2k

.dc VVBATT 0 10 1
.OP

.end
